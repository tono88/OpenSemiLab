* Fuente Thevenin 50 ohm, red LC y carga 50 ohm. VIN es voltaje en circuito abierto.
* A baja frecuencia V(out)/VIN~0.5 (-6.02 dB); NO confundirlo con S21.
.include schematic/matching.spice
VIN source 0 AC 1
RS source in 50
XMATCH in out matching
RL out 0 50
.ac dec 60 100Meg 10Gig
.print ac vdb(out) vp(out) vdb(in)
.meas ac passband_vgain FIND vdb(out) AT=100Meg
.meas ac center_vgain FIND vdb(out) AT=2.45Gig
.end
